ADE simulation setup
Run mode: Single Run, Sweeps and Corners
Tests:
  ECE555_RCA3_1: ECE555/RCA3/schematic, simulator hspiceD
