ADE simulation setup
Test ECE555_RCA3_1: ECE555/RCA3/schematic, simulator hspiceD
Run mode: Single Run, Sweeps and Corners
