**Test
.GLOBAL vss! vdd!
.TEMP 25.0
.OPTION
+    ARTIST=2
+    INGOLD=2
+    PARHIER=LOCAL
+    PSF=2
+    HIER_DELIM=0
+    PROBE
+    CSHUNT=1e-18
.options NUMDGT=8 measdgt=5 GMINDC=1e-18 DELMAX=1n method=gear INGOLD=2 POST=1
.INCLUDE "/cae/apps/data/asap7PDK-2022/asap7PDK_r1p7/models/hspice/7nm_TT_160803.pm"
.INCLUDE "Neuron_OPT.pex.netlist"
v1 vdd 0 0.9v
v2 vss 0 0v

vA1 A<1> 0 pwl 0ns 0.0v 1.000ns 0.0v 2.000ns 0.0v 3.000ns 0.0v 4.000ns 0.0v 5.000ns 0.0v 6.000ns 0.0v 7.000ns 0.0v 8.000ns 0.0v 9.000ns 0.0v 10.000ns 0.0v 11.000ns 0.0v 12.000ns 0.0v 13.000ns 0.0v 14.000ns 0.0v 15.000ns 0.0v 16.000ns 0.0v 17.000ns 0.0v 18.000ns 0.0v 19.000ns 0.0v 20.000ns 0.0v 21.000ns 0.0v 22.000ns 0.0v 23.000ns 0.0v 24.000ns 0.0v 25.000ns 0.0v 26.000ns 0.0v 27.000ns 0.0v 28.000ns 0.0v 29.000ns 0.0v 30.000ns 0.0v 31.000ns 0.0v 32.000ns 0.0v 33.000ns 0.0v 34.000ns 0.0v 35.000ns 0.0v 36.000ns 0.0v 37.000ns 0.0v 38.000ns 0.0v 39.000ns 0.0v 40.000ns 0.0v 41.000ns 0.0v 42.000ns 0.0v 43.000ns 0.0v 44.000ns 0.0v 45.000ns 0.0v 46.000ns 0.0v 47.000ns 0.0v 48.000ns 0.0v 49.000ns 0.0v 50.000ns 0.0v 51.000ns 0.0v 52.000ns 0.0v 53.000ns 0.0v 54.000ns 0.0v 55.000ns 0.0v 56.000ns 0.0v 57.000ns 0.0v 58.000ns 0.0v 59.000ns 0.0v 60.000ns 0.0v 61.000ns 0.0v 62.000ns 0.0v 63.000ns 0.0v 64.000ns 0.0v 65.000ns 0.0v 66.000ns 0.0v 67.000ns 0.0v 68.000ns 0.0v 69.000ns 0.0v 70.000ns 0.0v 71.000ns 0.0v 72.000ns 0.0v 73.000ns 0.0v 74.000ns 0.0v 75.000ns 0.0v 76.000ns 0.0v 77.000ns 0.0v 78.000ns 0.0v 79.000ns 0.0v 80.000ns 0.0v 81.000ns 0.0v 82.000ns 0.0v 83.000ns 0.0v 84.000ns 0.0v 85.000ns 0.0v 86.000ns 0.0v 87.000ns 0.0v 88.000ns 0.0v 89.000ns 0.0v 90.000ns 0.0v 91.000ns 0.0v 92.000ns 0.0v 93.000ns 0.0v 94.000ns 0.0v 95.000ns 0.0v 96.000ns 0.0v 97.000ns 0.0v 98.000ns 0.0v 99.000ns 0.0v 100.000ns 0.0v 101.000ns 0.0v 102.000ns 0.0v 103.000ns 0.0v 104.000ns 0.0v 105.000ns 0.0v 106.000ns 0.0v 107.000ns 0.0v 108.000ns 0.0v 109.000ns 0.0v 110.000ns 0.0v 111.000ns 0.0v 112.000ns 0.0v 113.000ns 0.0v 114.000ns 0.0v 115.000ns 0.0v 116.000ns 0.0v 117.000ns 0.0v 118.000ns 0.0v 119.000ns 0.0v 120.000ns 0.0v 121.000ns 0.0v 122.000ns 0.0v 123.000ns 0.0v 124.000ns 0.0v 125.000ns 0.0v 126.000ns 0.0v 127.000ns 0.0v 128.000ns 0.0v 129.000ns 0.0v 130.000ns 0.0v 131.000ns 0.0v 132.000ns 0.0v 133.000ns 0.0v 134.000ns 0.0v 135.000ns 0.0v 136.000ns 0.0v 137.000ns 0.0v 138.000ns 0.0v 139.000ns 0.0v 140.000ns 0.0v 141.000ns 0.0v 142.000ns 0.0v 143.000ns 0.0v 144.000ns 0.0v 145.000ns 0.0v 146.000ns 0.0v 147.000ns 0.0v 148.000ns 0.0v 149.000ns 0.0v 150.000ns 0.0v 151.000ns 0.0v 152.000ns 0.0v 153.000ns 0.0v 154.000ns 0.0v 155.000ns 0.0v 156.000ns 0.0v 157.000ns 0.0v 158.000ns 0.0v 159.000ns 0.0v 160.000ns 0.0v 161.000ns 0.0v 161.000ns 0.0v 161.025ns 0.9v 162.000ns 0.9v 163.000ns 0.9v 164.000ns 0.9v 165.000ns 0.9v 166.000ns 0.9v 167.000ns 0.9v 168.000ns 0.9v 169.000ns 0.9v 170.000ns 0.9v 171.000ns 0.9v 172.000ns 0.9v 173.000ns 0.9v 174.000ns 0.9v 175.000ns 0.9v 176.000ns 0.9v 177.000ns 0.9v 178.000ns 0.9v 179.000ns 0.9v 180.000ns 0.9v 181.000ns 0.9v 182.000ns 0.9v 183.000ns 0.9v 184.000ns 0.9v 185.000ns 0.9v 186.000ns 0.9v 187.000ns 0.9v 188.000ns 0.9v 189.000ns 0.9v 190.000ns 0.9v 191.000ns 0.9v 192.000ns 0.9v 193.000ns 0.9v 194.000ns 0.9v 195.000ns 0.9v 196.000ns 0.9v 197.000ns 0.9v 198.000ns 0.9v 199.000ns 0.9v 200.000ns 0.9v 201.000ns 0.9v 202.000ns 0.9v 203.000ns 0.9v 204.000ns 0.9v 205.000ns 0.9v 206.000ns 0.9v 207.000ns 0.9v 208.000ns 0.9v 209.000ns 0.9v 210.000ns 0.9v 211.000ns 0.9v 212.000ns 0.9v 213.000ns 0.9v 214.000ns 0.9v 215.000ns 0.9v 216.000ns 0.9v 217.000ns 0.9v 218.000ns 0.9v 219.000ns 0.9v 220.000ns 0.9v 221.000ns 0.9v 222.000ns 0.9v 223.000ns 0.9v 224.000ns 0.9v 225.000ns 0.9v 226.000ns 0.9v 227.000ns 0.9v 228.000ns 0.9v 229.000ns 0.9v 230.000ns 0.9v 231.000ns 0.9v 232.000ns 0.9v 233.000ns 0.9v 234.000ns 0.9v 235.000ns 0.9v 236.000ns 0.9v 237.000ns 0.9v 238.000ns 0.9v 239.000ns 0.9v 240.000ns 0.9v 241.000ns 0.9v 242.000ns 0.9v

vA0 A<0> 0 pwl 0ns 0.0v 1.000ns 0.0v 2.000ns 0.0v 3.000ns 0.0v 4.000ns 0.0v 5.000ns 0.0v 6.000ns 0.0v 7.000ns 0.0v 8.000ns 0.0v 9.000ns 0.0v 10.000ns 0.0v 11.000ns 0.0v 12.000ns 0.0v 13.000ns 0.0v 14.000ns 0.0v 15.000ns 0.0v 16.000ns 0.0v 17.000ns 0.0v 18.000ns 0.0v 19.000ns 0.0v 20.000ns 0.0v 21.000ns 0.0v 22.000ns 0.0v 23.000ns 0.0v 24.000ns 0.0v 25.000ns 0.0v 26.000ns 0.0v 27.000ns 0.0v 28.000ns 0.0v 29.000ns 0.0v 30.000ns 0.0v 31.000ns 0.0v 32.000ns 0.0v 33.000ns 0.0v 34.000ns 0.0v 35.000ns 0.0v 36.000ns 0.0v 37.000ns 0.0v 38.000ns 0.0v 39.000ns 0.0v 40.000ns 0.0v 41.000ns 0.0v 42.000ns 0.0v 43.000ns 0.0v 44.000ns 0.0v 45.000ns 0.0v 46.000ns 0.0v 47.000ns 0.0v 48.000ns 0.0v 49.000ns 0.0v 50.000ns 0.0v 51.000ns 0.0v 52.000ns 0.0v 53.000ns 0.0v 54.000ns 0.0v 55.000ns 0.0v 56.000ns 0.0v 57.000ns 0.0v 58.000ns 0.0v 59.000ns 0.0v 60.000ns 0.0v 61.000ns 0.0v 62.000ns 0.0v 63.000ns 0.0v 64.000ns 0.0v 65.000ns 0.0v 66.000ns 0.0v 67.000ns 0.0v 68.000ns 0.0v 69.000ns 0.0v 70.000ns 0.0v 71.000ns 0.0v 72.000ns 0.0v 73.000ns 0.0v 74.000ns 0.0v 75.000ns 0.0v 76.000ns 0.0v 77.000ns 0.0v 78.000ns 0.0v 79.000ns 0.0v 80.000ns 0.0v 80.000ns 0.0v 80.025ns 0.9v 81.000ns 0.9v 82.000ns 0.9v 83.000ns 0.9v 84.000ns 0.9v 85.000ns 0.9v 86.000ns 0.9v 87.000ns 0.9v 88.000ns 0.9v 89.000ns 0.9v 90.000ns 0.9v 91.000ns 0.9v 92.000ns 0.9v 93.000ns 0.9v 94.000ns 0.9v 95.000ns 0.9v 96.000ns 0.9v 97.000ns 0.9v 98.000ns 0.9v 99.000ns 0.9v 100.000ns 0.9v 101.000ns 0.9v 102.000ns 0.9v 103.000ns 0.9v 104.000ns 0.9v 105.000ns 0.9v 106.000ns 0.9v 107.000ns 0.9v 108.000ns 0.9v 109.000ns 0.9v 110.000ns 0.9v 111.000ns 0.9v 112.000ns 0.9v 113.000ns 0.9v 114.000ns 0.9v 115.000ns 0.9v 116.000ns 0.9v 117.000ns 0.9v 118.000ns 0.9v 119.000ns 0.9v 120.000ns 0.9v 121.000ns 0.9v 122.000ns 0.9v 123.000ns 0.9v 124.000ns 0.9v 125.000ns 0.9v 126.000ns 0.9v 127.000ns 0.9v 128.000ns 0.9v 129.000ns 0.9v 130.000ns 0.9v 131.000ns 0.9v 132.000ns 0.9v 133.000ns 0.9v 134.000ns 0.9v 135.000ns 0.9v 136.000ns 0.9v 137.000ns 0.9v 138.000ns 0.9v 139.000ns 0.9v 140.000ns 0.9v 141.000ns 0.9v 142.000ns 0.9v 143.000ns 0.9v 144.000ns 0.9v 145.000ns 0.9v 146.000ns 0.9v 147.000ns 0.9v 148.000ns 0.9v 149.000ns 0.9v 150.000ns 0.9v 151.000ns 0.9v 152.000ns 0.9v 153.000ns 0.9v 154.000ns 0.9v 155.000ns 0.9v 156.000ns 0.9v 157.000ns 0.9v 158.000ns 0.9v 159.000ns 0.9v 160.000ns 0.9v 161.000ns 0.9v 162.000ns 0.9v 163.000ns 0.9v 164.000ns 0.9v 165.000ns 0.9v 166.000ns 0.9v 167.000ns 0.9v 168.000ns 0.9v 169.000ns 0.9v 170.000ns 0.9v 171.000ns 0.9v 172.000ns 0.9v 173.000ns 0.9v 174.000ns 0.9v 175.000ns 0.9v 176.000ns 0.9v 177.000ns 0.9v 178.000ns 0.9v 179.000ns 0.9v 180.000ns 0.9v 181.000ns 0.9v 182.000ns 0.9v 183.000ns 0.9v 184.000ns 0.9v 185.000ns 0.9v 186.000ns 0.9v 187.000ns 0.9v 188.000ns 0.9v 189.000ns 0.9v 190.000ns 0.9v 191.000ns 0.9v 192.000ns 0.9v 193.000ns 0.9v 194.000ns 0.9v 195.000ns 0.9v 196.000ns 0.9v 197.000ns 0.9v 198.000ns 0.9v 199.000ns 0.9v 200.000ns 0.9v 201.000ns 0.9v 202.000ns 0.9v 203.000ns 0.9v 204.000ns 0.9v 205.000ns 0.9v 206.000ns 0.9v 207.000ns 0.9v 208.000ns 0.9v 209.000ns 0.9v 210.000ns 0.9v 211.000ns 0.9v 212.000ns 0.9v 213.000ns 0.9v 214.000ns 0.9v 215.000ns 0.9v 216.000ns 0.9v 217.000ns 0.9v 218.000ns 0.9v 219.000ns 0.9v 220.000ns 0.9v 221.000ns 0.9v 222.000ns 0.9v 223.000ns 0.9v 224.000ns 0.9v 225.000ns 0.9v 226.000ns 0.9v 227.000ns 0.9v 228.000ns 0.9v 229.000ns 0.9v 230.000ns 0.9v 231.000ns 0.9v 232.000ns 0.9v 233.000ns 0.9v 234.000ns 0.9v 235.000ns 0.9v 236.000ns 0.9v 237.000ns 0.9v 238.000ns 0.9v 239.000ns 0.9v 240.000ns 0.9v 241.000ns 0.9v 242.000ns 0.9v

vB1 B<1> 0 pwl 0ns 0.0v 1.000ns 0.0v 2.000ns 0.0v 3.000ns 0.0v 4.000ns 0.0v 5.000ns 0.0v 6.000ns 0.0v 7.000ns 0.0v 8.000ns 0.0v 9.000ns 0.0v 10.000ns 0.0v 11.000ns 0.0v 12.000ns 0.0v 13.000ns 0.0v 14.000ns 0.0v 15.000ns 0.0v 16.000ns 0.0v 17.000ns 0.0v 18.000ns 0.0v 19.000ns 0.0v 20.000ns 0.0v 21.000ns 0.0v 22.000ns 0.0v 23.000ns 0.0v 24.000ns 0.0v 25.000ns 0.0v 26.000ns 0.0v 27.000ns 0.0v 28.000ns 0.0v 29.000ns 0.0v 30.000ns 0.0v 31.000ns 0.0v 32.000ns 0.0v 33.000ns 0.0v 34.000ns 0.0v 35.000ns 0.0v 36.000ns 0.0v 37.000ns 0.0v 38.000ns 0.0v 39.000ns 0.0v 40.000ns 0.0v 41.000ns 0.0v 42.000ns 0.0v 43.000ns 0.0v 44.000ns 0.0v 45.000ns 0.0v 46.000ns 0.0v 47.000ns 0.0v 48.000ns 0.0v 49.000ns 0.0v 50.000ns 0.0v 51.000ns 0.0v 52.000ns 0.0v 53.000ns 0.0v 53.000ns 0.0v 53.025ns 0.9v 54.000ns 0.9v 55.000ns 0.9v 56.000ns 0.9v 57.000ns 0.9v 58.000ns 0.9v 59.000ns 0.9v 60.000ns 0.9v 61.000ns 0.9v 62.000ns 0.9v 63.000ns 0.9v 64.000ns 0.9v 65.000ns 0.9v 66.000ns 0.9v 67.000ns 0.9v 68.000ns 0.9v 69.000ns 0.9v 70.000ns 0.9v 71.000ns 0.9v 72.000ns 0.9v 73.000ns 0.9v 74.000ns 0.9v 75.000ns 0.9v 76.000ns 0.9v 77.000ns 0.9v 78.000ns 0.9v 79.000ns 0.9v 80.000ns 0.9v 81.000ns 0.9v 82.000ns 0.9v 83.000ns 0.9v 84.000ns 0.9v 85.000ns 0.9v 86.000ns 0.9v 87.000ns 0.9v 88.000ns 0.9v 89.000ns 0.9v 90.000ns 0.9v 91.000ns 0.9v 92.000ns 0.9v 93.000ns 0.9v 94.000ns 0.9v 95.000ns 0.9v 96.000ns 0.9v 97.000ns 0.9v 98.000ns 0.9v 99.000ns 0.9v 100.000ns 0.9v 101.000ns 0.9v 102.000ns 0.9v 103.000ns 0.9v 104.000ns 0.9v 105.000ns 0.9v 106.000ns 0.9v 107.000ns 0.9v 107.000ns 0.9v 107.025ns 0.0v 108.000ns 0.0v 109.000ns 0.0v 110.000ns 0.0v 111.000ns 0.0v 112.000ns 0.0v 113.000ns 0.0v 114.000ns 0.0v 115.000ns 0.0v 116.000ns 0.0v 117.000ns 0.0v 118.000ns 0.0v 119.000ns 0.0v 120.000ns 0.0v 121.000ns 0.0v 122.000ns 0.0v 123.000ns 0.0v 124.000ns 0.0v 125.000ns 0.0v 126.000ns 0.0v 127.000ns 0.0v 128.000ns 0.0v 129.000ns 0.0v 130.000ns 0.0v 131.000ns 0.0v 132.000ns 0.0v 133.000ns 0.0v 134.000ns 0.0v 135.000ns 0.0v 136.000ns 0.0v 137.000ns 0.0v 138.000ns 0.0v 139.000ns 0.0v 140.000ns 0.0v 141.000ns 0.0v 142.000ns 0.0v 143.000ns 0.0v 144.000ns 0.0v 145.000ns 0.0v 146.000ns 0.0v 147.000ns 0.0v 148.000ns 0.0v 149.000ns 0.0v 150.000ns 0.0v 151.000ns 0.0v 152.000ns 0.0v 153.000ns 0.0v 154.000ns 0.0v 155.000ns 0.0v 156.000ns 0.0v 157.000ns 0.0v 158.000ns 0.0v 159.000ns 0.0v 160.000ns 0.0v 161.000ns 0.0v 162.000ns 0.0v 163.000ns 0.0v 164.000ns 0.0v 165.000ns 0.0v 166.000ns 0.0v 167.000ns 0.0v 168.000ns 0.0v 169.000ns 0.0v 170.000ns 0.0v 171.000ns 0.0v 172.000ns 0.0v 173.000ns 0.0v 174.000ns 0.0v 175.000ns 0.0v 176.000ns 0.0v 177.000ns 0.0v 178.000ns 0.0v 179.000ns 0.0v 180.000ns 0.0v 181.000ns 0.0v 182.000ns 0.0v 183.000ns 0.0v 184.000ns 0.0v 185.000ns 0.0v 186.000ns 0.0v 187.000ns 0.0v 188.000ns 0.0v 189.000ns 0.0v 190.000ns 0.0v 191.000ns 0.0v 192.000ns 0.0v 193.000ns 0.0v 194.000ns 0.0v 195.000ns 0.0v 196.000ns 0.0v 197.000ns 0.0v 198.000ns 0.0v 199.000ns 0.0v 200.000ns 0.0v 201.000ns 0.0v 202.000ns 0.0v 203.000ns 0.0v 204.000ns 0.0v 205.000ns 0.0v 206.000ns 0.0v 207.000ns 0.0v 208.000ns 0.0v 209.000ns 0.0v 210.000ns 0.0v 211.000ns 0.0v 212.000ns 0.0v 213.000ns 0.0v 214.000ns 0.0v 215.000ns 0.0v 215.000ns 0.0v 215.025ns 0.9v 216.000ns 0.9v 217.000ns 0.9v 218.000ns 0.9v 219.000ns 0.9v 220.000ns 0.9v 221.000ns 0.9v 222.000ns 0.9v 223.000ns 0.9v 224.000ns 0.9v 225.000ns 0.9v 226.000ns 0.9v 227.000ns 0.9v 228.000ns 0.9v 229.000ns 0.9v 230.000ns 0.9v 231.000ns 0.9v 232.000ns 0.9v 233.000ns 0.9v 234.000ns 0.9v 235.000ns 0.9v 236.000ns 0.9v 237.000ns 0.9v 238.000ns 0.9v 239.000ns 0.9v 240.000ns 0.9v 241.000ns 0.9v 242.000ns 0.9v

vB0 B<0> 0 pwl 0ns 0.0v 1.000ns 0.0v 2.000ns 0.0v 3.000ns 0.0v 4.000ns 0.0v 5.000ns 0.0v 6.000ns 0.0v 7.000ns 0.0v 8.000ns 0.0v 9.000ns 0.0v 10.000ns 0.0v 11.000ns 0.0v 12.000ns 0.0v 13.000ns 0.0v 14.000ns 0.0v 15.000ns 0.0v 16.000ns 0.0v 17.000ns 0.0v 18.000ns 0.0v 19.000ns 0.0v 20.000ns 0.0v 21.000ns 0.0v 22.000ns 0.0v 23.000ns 0.0v 24.000ns 0.0v 25.000ns 0.0v 26.000ns 0.0v 26.000ns 0.0v 26.025ns 0.9v 27.000ns 0.9v 28.000ns 0.9v 29.000ns 0.9v 30.000ns 0.9v 31.000ns 0.9v 32.000ns 0.9v 33.000ns 0.9v 34.000ns 0.9v 35.000ns 0.9v 36.000ns 0.9v 37.000ns 0.9v 38.000ns 0.9v 39.000ns 0.9v 40.000ns 0.9v 41.000ns 0.9v 42.000ns 0.9v 43.000ns 0.9v 44.000ns 0.9v 45.000ns 0.9v 46.000ns 0.9v 47.000ns 0.9v 48.000ns 0.9v 49.000ns 0.9v 50.000ns 0.9v 51.000ns 0.9v 52.000ns 0.9v 53.000ns 0.9v 54.000ns 0.9v 55.000ns 0.9v 56.000ns 0.9v 57.000ns 0.9v 58.000ns 0.9v 59.000ns 0.9v 60.000ns 0.9v 61.000ns 0.9v 62.000ns 0.9v 63.000ns 0.9v 64.000ns 0.9v 65.000ns 0.9v 66.000ns 0.9v 67.000ns 0.9v 68.000ns 0.9v 69.000ns 0.9v 70.000ns 0.9v 71.000ns 0.9v 72.000ns 0.9v 73.000ns 0.9v 74.000ns 0.9v 75.000ns 0.9v 76.000ns 0.9v 77.000ns 0.9v 78.000ns 0.9v 79.000ns 0.9v 80.000ns 0.9v 81.000ns 0.9v 82.000ns 0.9v 83.000ns 0.9v 84.000ns 0.9v 85.000ns 0.9v 86.000ns 0.9v 87.000ns 0.9v 88.000ns 0.9v 89.000ns 0.9v 90.000ns 0.9v 91.000ns 0.9v 92.000ns 0.9v 93.000ns 0.9v 94.000ns 0.9v 95.000ns 0.9v 96.000ns 0.9v 97.000ns 0.9v 98.000ns 0.9v 99.000ns 0.9v 100.000ns 0.9v 101.000ns 0.9v 102.000ns 0.9v 103.000ns 0.9v 104.000ns 0.9v 105.000ns 0.9v 106.000ns 0.9v 107.000ns 0.9v 108.000ns 0.9v 109.000ns 0.9v 110.000ns 0.9v 111.000ns 0.9v 112.000ns 0.9v 113.000ns 0.9v 114.000ns 0.9v 115.000ns 0.9v 116.000ns 0.9v 117.000ns 0.9v 118.000ns 0.9v 119.000ns 0.9v 120.000ns 0.9v 121.000ns 0.9v 122.000ns 0.9v 123.000ns 0.9v 124.000ns 0.9v 125.000ns 0.9v 126.000ns 0.9v 127.000ns 0.9v 128.000ns 0.9v 129.000ns 0.9v 130.000ns 0.9v 131.000ns 0.9v 132.000ns 0.9v 133.000ns 0.9v 134.000ns 0.9v 134.000ns 0.9v 134.025ns 0.0v 135.000ns 0.0v 136.000ns 0.0v 137.000ns 0.0v 138.000ns 0.0v 139.000ns 0.0v 140.000ns 0.0v 141.000ns 0.0v 142.000ns 0.0v 143.000ns 0.0v 144.000ns 0.0v 145.000ns 0.0v 146.000ns 0.0v 147.000ns 0.0v 148.000ns 0.0v 149.000ns 0.0v 150.000ns 0.0v 151.000ns 0.0v 152.000ns 0.0v 153.000ns 0.0v 154.000ns 0.0v 155.000ns 0.0v 156.000ns 0.0v 157.000ns 0.0v 158.000ns 0.0v 159.000ns 0.0v 160.000ns 0.0v 161.000ns 0.0v 162.000ns 0.0v 163.000ns 0.0v 164.000ns 0.0v 165.000ns 0.0v 166.000ns 0.0v 167.000ns 0.0v 168.000ns 0.0v 169.000ns 0.0v 170.000ns 0.0v 171.000ns 0.0v 172.000ns 0.0v 173.000ns 0.0v 174.000ns 0.0v 175.000ns 0.0v 176.000ns 0.0v 177.000ns 0.0v 178.000ns 0.0v 179.000ns 0.0v 180.000ns 0.0v 181.000ns 0.0v 182.000ns 0.0v 183.000ns 0.0v 184.000ns 0.0v 185.000ns 0.0v 186.000ns 0.0v 187.000ns 0.0v 188.000ns 0.0v 188.000ns 0.0v 188.025ns 0.9v 189.000ns 0.9v 190.000ns 0.9v 191.000ns 0.9v 192.000ns 0.9v 193.000ns 0.9v 194.000ns 0.9v 195.000ns 0.9v 196.000ns 0.9v 197.000ns 0.9v 198.000ns 0.9v 199.000ns 0.9v 200.000ns 0.9v 201.000ns 0.9v 202.000ns 0.9v 203.000ns 0.9v 204.000ns 0.9v 205.000ns 0.9v 206.000ns 0.9v 207.000ns 0.9v 208.000ns 0.9v 209.000ns 0.9v 210.000ns 0.9v 211.000ns 0.9v 212.000ns 0.9v 213.000ns 0.9v 214.000ns 0.9v 215.000ns 0.9v 216.000ns 0.9v 217.000ns 0.9v 218.000ns 0.9v 219.000ns 0.9v 220.000ns 0.9v 221.000ns 0.9v 222.000ns 0.9v 223.000ns 0.9v 224.000ns 0.9v 225.000ns 0.9v 226.000ns 0.9v 227.000ns 0.9v 228.000ns 0.9v 229.000ns 0.9v 230.000ns 0.9v 231.000ns 0.9v 232.000ns 0.9v 233.000ns 0.9v 234.000ns 0.9v 235.000ns 0.9v 236.000ns 0.9v 237.000ns 0.9v 238.000ns 0.9v 239.000ns 0.9v 240.000ns 0.9v 241.000ns 0.9v 242.000ns 0.9v

vW00_1 W00<1> 0 pwl 0ns 0.0v 1.000ns 0.0v 2.000ns 0.0v 3.000ns 0.0v 4.000ns 0.0v 5.000ns 0.0v 6.000ns 0.0v 7.000ns 0.0v 8.000ns 0.0v 9.000ns 0.0v 10.000ns 0.0v 11.000ns 0.0v 12.000ns 0.0v 13.000ns 0.0v 14.000ns 0.0v 15.000ns 0.0v 16.000ns 0.0v 17.000ns 0.0v 17.000ns 0.0v 17.025ns 0.9v 18.000ns 0.9v 19.000ns 0.9v 20.000ns 0.9v 21.000ns 0.9v 22.000ns 0.9v 23.000ns 0.9v 24.000ns 0.9v 25.000ns 0.9v 26.000ns 0.9v 27.000ns 0.9v 28.000ns 0.9v 29.000ns 0.9v 30.000ns 0.9v 31.000ns 0.9v 32.000ns 0.9v 33.000ns 0.9v 34.000ns 0.9v 35.000ns 0.9v 35.000ns 0.9v 35.025ns 0.0v 36.000ns 0.0v 37.000ns 0.0v 38.000ns 0.0v 39.000ns 0.0v 40.000ns 0.0v 41.000ns 0.0v 42.000ns 0.0v 43.000ns 0.0v 44.000ns 0.0v 45.000ns 0.0v 46.000ns 0.0v 47.000ns 0.0v 48.000ns 0.0v 49.000ns 0.0v 50.000ns 0.0v 51.000ns 0.0v 52.000ns 0.0v 53.000ns 0.0v 54.000ns 0.0v 55.000ns 0.0v 56.000ns 0.0v 57.000ns 0.0v 58.000ns 0.0v 59.000ns 0.0v 60.000ns 0.0v 61.000ns 0.0v 62.000ns 0.0v 63.000ns 0.0v 64.000ns 0.0v 65.000ns 0.0v 66.000ns 0.0v 67.000ns 0.0v 68.000ns 0.0v 69.000ns 0.0v 70.000ns 0.0v 71.000ns 0.0v 71.000ns 0.0v 71.025ns 0.9v 72.000ns 0.9v 73.000ns 0.9v 74.000ns 0.9v 75.000ns 0.9v 76.000ns 0.9v 77.000ns 0.9v 78.000ns 0.9v 79.000ns 0.9v 80.000ns 0.9v 81.000ns 0.9v 82.000ns 0.9v 83.000ns 0.9v 84.000ns 0.9v 85.000ns 0.9v 86.000ns 0.9v 87.000ns 0.9v 88.000ns 0.9v 89.000ns 0.9v 89.000ns 0.9v 89.025ns 0.0v 90.000ns 0.0v 91.000ns 0.0v 92.000ns 0.0v 93.000ns 0.0v 94.000ns 0.0v 95.000ns 0.0v 96.000ns 0.0v 97.000ns 0.0v 98.000ns 0.0v 99.000ns 0.0v 100.000ns 0.0v 101.000ns 0.0v 102.000ns 0.0v 103.000ns 0.0v 104.000ns 0.0v 105.000ns 0.0v 106.000ns 0.0v 107.000ns 0.0v 108.000ns 0.0v 109.000ns 0.0v 110.000ns 0.0v 111.000ns 0.0v 112.000ns 0.0v 113.000ns 0.0v 114.000ns 0.0v 115.000ns 0.0v 116.000ns 0.0v 117.000ns 0.0v 118.000ns 0.0v 119.000ns 0.0v 120.000ns 0.0v 121.000ns 0.0v 122.000ns 0.0v 123.000ns 0.0v 124.000ns 0.0v 125.000ns 0.0v 125.000ns 0.0v 125.025ns 0.9v 126.000ns 0.9v 127.000ns 0.9v 128.000ns 0.9v 129.000ns 0.9v 130.000ns 0.9v 131.000ns 0.9v 132.000ns 0.9v 133.000ns 0.9v 134.000ns 0.9v 135.000ns 0.9v 136.000ns 0.9v 137.000ns 0.9v 138.000ns 0.9v 139.000ns 0.9v 140.000ns 0.9v 141.000ns 0.9v 142.000ns 0.9v 143.000ns 0.9v 143.000ns 0.9v 143.025ns 0.0v 144.000ns 0.0v 145.000ns 0.0v 146.000ns 0.0v 147.000ns 0.0v 148.000ns 0.0v 149.000ns 0.0v 150.000ns 0.0v 151.000ns 0.0v 152.000ns 0.0v 153.000ns 0.0v 154.000ns 0.0v 155.000ns 0.0v 156.000ns 0.0v 157.000ns 0.0v 158.000ns 0.0v 159.000ns 0.0v 160.000ns 0.0v 161.000ns 0.0v 162.000ns 0.0v 163.000ns 0.0v 164.000ns 0.0v 165.000ns 0.0v 166.000ns 0.0v 167.000ns 0.0v 168.000ns 0.0v 169.000ns 0.0v 170.000ns 0.0v 171.000ns 0.0v 172.000ns 0.0v 173.000ns 0.0v 174.000ns 0.0v 175.000ns 0.0v 176.000ns 0.0v 177.000ns 0.0v 178.000ns 0.0v 179.000ns 0.0v 179.000ns 0.0v 179.025ns 0.9v 180.000ns 0.9v 181.000ns 0.9v 182.000ns 0.9v 183.000ns 0.9v 184.000ns 0.9v 185.000ns 0.9v 186.000ns 0.9v 187.000ns 0.9v 188.000ns 0.9v 189.000ns 0.9v 190.000ns 0.9v 191.000ns 0.9v 192.000ns 0.9v 193.000ns 0.9v 194.000ns 0.9v 195.000ns 0.9v 196.000ns 0.9v 197.000ns 0.9v 197.000ns 0.9v 197.025ns 0.0v 198.000ns 0.0v 199.000ns 0.0v 200.000ns 0.0v 201.000ns 0.0v 202.000ns 0.0v 203.000ns 0.0v 204.000ns 0.0v 205.000ns 0.0v 206.000ns 0.0v 207.000ns 0.0v 208.000ns 0.0v 209.000ns 0.0v 210.000ns 0.0v 211.000ns 0.0v 212.000ns 0.0v 213.000ns 0.0v 214.000ns 0.0v 215.000ns 0.0v 216.000ns 0.0v 217.000ns 0.0v 218.000ns 0.0v 219.000ns 0.0v 220.000ns 0.0v 221.000ns 0.0v 222.000ns 0.0v 223.000ns 0.0v 224.000ns 0.0v 225.000ns 0.0v 226.000ns 0.0v 227.000ns 0.0v 228.000ns 0.0v 229.000ns 0.0v 230.000ns 0.0v 231.000ns 0.0v 232.000ns 0.0v 233.000ns 0.0v 233.000ns 0.0v 233.025ns 0.9v 234.000ns 0.9v 235.000ns 0.9v 236.000ns 0.9v 237.000ns 0.9v 238.000ns 0.9v 239.000ns 0.9v 240.000ns 0.9v 241.000ns 0.9v 242.000ns 0.9v

vW00_0 W00<0> 0 pwl 0ns 0.0v 1.000ns 0.0v 2.000ns 0.0v 3.000ns 0.0v 4.000ns 0.0v 5.000ns 0.0v 6.000ns 0.0v 7.000ns 0.0v 8.000ns 0.0v 8.000ns 0.0v 8.025ns 0.9v 9.000ns 0.9v 10.000ns 0.9v 11.000ns 0.9v 12.000ns 0.9v 13.000ns 0.9v 14.000ns 0.9v 15.000ns 0.9v 16.000ns 0.9v 17.000ns 0.9v 18.000ns 0.9v 19.000ns 0.9v 20.000ns 0.9v 21.000ns 0.9v 22.000ns 0.9v 23.000ns 0.9v 24.000ns 0.9v 25.000ns 0.9v 26.000ns 0.9v 27.000ns 0.9v 28.000ns 0.9v 29.000ns 0.9v 30.000ns 0.9v 31.000ns 0.9v 32.000ns 0.9v 33.000ns 0.9v 34.000ns 0.9v 35.000ns 0.9v 36.000ns 0.9v 37.000ns 0.9v 38.000ns 0.9v 39.000ns 0.9v 40.000ns 0.9v 41.000ns 0.9v 42.000ns 0.9v 43.000ns 0.9v 44.000ns 0.9v 44.000ns 0.9v 44.025ns 0.0v 45.000ns 0.0v 46.000ns 0.0v 47.000ns 0.0v 48.000ns 0.0v 49.000ns 0.0v 50.000ns 0.0v 51.000ns 0.0v 52.000ns 0.0v 53.000ns 0.0v 54.000ns 0.0v 55.000ns 0.0v 56.000ns 0.0v 57.000ns 0.0v 58.000ns 0.0v 59.000ns 0.0v 60.000ns 0.0v 61.000ns 0.0v 62.000ns 0.0v 62.000ns 0.0v 62.025ns 0.9v 63.000ns 0.9v 64.000ns 0.9v 65.000ns 0.9v 66.000ns 0.9v 67.000ns 0.9v 68.000ns 0.9v 69.000ns 0.9v 70.000ns 0.9v 71.000ns 0.9v 72.000ns 0.9v 73.000ns 0.9v 74.000ns 0.9v 75.000ns 0.9v 76.000ns 0.9v 77.000ns 0.9v 78.000ns 0.9v 79.000ns 0.9v 80.000ns 0.9v 81.000ns 0.9v 82.000ns 0.9v 83.000ns 0.9v 84.000ns 0.9v 85.000ns 0.9v 86.000ns 0.9v 87.000ns 0.9v 88.000ns 0.9v 89.000ns 0.9v 90.000ns 0.9v 91.000ns 0.9v 92.000ns 0.9v 93.000ns 0.9v 94.000ns 0.9v 95.000ns 0.9v 96.000ns 0.9v 97.000ns 0.9v 98.000ns 0.9v 98.000ns 0.9v 98.025ns 0.0v 99.000ns 0.0v 100.000ns 0.0v 101.000ns 0.0v 102.000ns 0.0v 103.000ns 0.0v 104.000ns 0.0v 105.000ns 0.0v 106.000ns 0.0v 107.000ns 0.0v 108.000ns 0.0v 109.000ns 0.0v 110.000ns 0.0v 111.000ns 0.0v 112.000ns 0.0v 113.000ns 0.0v 114.000ns 0.0v 115.000ns 0.0v 116.000ns 0.0v 116.000ns 0.0v 116.025ns 0.9v 117.000ns 0.9v 118.000ns 0.9v 119.000ns 0.9v 120.000ns 0.9v 121.000ns 0.9v 122.000ns 0.9v 123.000ns 0.9v 124.000ns 0.9v 125.000ns 0.9v 126.000ns 0.9v 127.000ns 0.9v 128.000ns 0.9v 129.000ns 0.9v 130.000ns 0.9v 131.000ns 0.9v 132.000ns 0.9v 133.000ns 0.9v 134.000ns 0.9v 135.000ns 0.9v 136.000ns 0.9v 137.000ns 0.9v 138.000ns 0.9v 139.000ns 0.9v 140.000ns 0.9v 141.000ns 0.9v 142.000ns 0.9v 143.000ns 0.9v 144.000ns 0.9v 145.000ns 0.9v 146.000ns 0.9v 147.000ns 0.9v 148.000ns 0.9v 149.000ns 0.9v 150.000ns 0.9v 151.000ns 0.9v 152.000ns 0.9v 152.000ns 0.9v 152.025ns 0.0v 153.000ns 0.0v 154.000ns 0.0v 155.000ns 0.0v 156.000ns 0.0v 157.000ns 0.0v 158.000ns 0.0v 159.000ns 0.0v 160.000ns 0.0v 161.000ns 0.0v 162.000ns 0.0v 163.000ns 0.0v 164.000ns 0.0v 165.000ns 0.0v 166.000ns 0.0v 167.000ns 0.0v 168.000ns 0.0v 169.000ns 0.0v 170.000ns 0.0v 170.000ns 0.0v 170.025ns 0.9v 171.000ns 0.9v 172.000ns 0.9v 173.000ns 0.9v 174.000ns 0.9v 175.000ns 0.9v 176.000ns 0.9v 177.000ns 0.9v 178.000ns 0.9v 179.000ns 0.9v 180.000ns 0.9v 181.000ns 0.9v 182.000ns 0.9v 183.000ns 0.9v 184.000ns 0.9v 185.000ns 0.9v 186.000ns 0.9v 187.000ns 0.9v 188.000ns 0.9v 189.000ns 0.9v 190.000ns 0.9v 191.000ns 0.9v 192.000ns 0.9v 193.000ns 0.9v 194.000ns 0.9v 195.000ns 0.9v 196.000ns 0.9v 197.000ns 0.9v 198.000ns 0.9v 199.000ns 0.9v 200.000ns 0.9v 201.000ns 0.9v 202.000ns 0.9v 203.000ns 0.9v 204.000ns 0.9v 205.000ns 0.9v 206.000ns 0.9v 206.000ns 0.9v 206.025ns 0.0v 207.000ns 0.0v 208.000ns 0.0v 209.000ns 0.0v 210.000ns 0.0v 211.000ns 0.0v 212.000ns 0.0v 213.000ns 0.0v 214.000ns 0.0v 215.000ns 0.0v 216.000ns 0.0v 217.000ns 0.0v 218.000ns 0.0v 219.000ns 0.0v 220.000ns 0.0v 221.000ns 0.0v 222.000ns 0.0v 223.000ns 0.0v 224.000ns 0.0v 224.000ns 0.0v 224.025ns 0.9v 225.000ns 0.9v 226.000ns 0.9v 227.000ns 0.9v 228.000ns 0.9v 229.000ns 0.9v 230.000ns 0.9v 231.000ns 0.9v 232.000ns 0.9v 233.000ns 0.9v 234.000ns 0.9v 235.000ns 0.9v 236.000ns 0.9v 237.000ns 0.9v 238.000ns 0.9v 239.000ns 0.9v 240.000ns 0.9v 241.000ns 0.9v 242.000ns 0.9v

vW10_1 W10<1> 0 pwl 0ns 0.0v 1.000ns 0.0v 1.000ns 0.0v 1.025ns 0.9v 2.000ns 0.9v 3.000ns 0.9v 3.000ns 0.9v 3.025ns 0.0v 4.000ns 0.0v 5.000ns 0.0v 6.000ns 0.0v 7.000ns 0.0v 7.000ns 0.0v 7.025ns 0.9v 8.000ns 0.9v 9.000ns 0.9v 9.000ns 0.9v 9.025ns 0.0v 10.000ns 0.0v 11.000ns 0.0v 12.000ns 0.0v 13.000ns 0.0v 13.000ns 0.0v 13.025ns 0.9v 14.000ns 0.9v 15.000ns 0.9v 15.000ns 0.9v 15.025ns 0.0v 16.000ns 0.0v 17.000ns 0.0v 18.000ns 0.0v 19.000ns 0.0v 19.000ns 0.0v 19.025ns 0.9v 20.000ns 0.9v 21.000ns 0.9v 21.000ns 0.9v 21.025ns 0.0v 22.000ns 0.0v 23.000ns 0.0v 24.000ns 0.0v 25.000ns 0.0v 25.000ns 0.0v 25.025ns 0.9v 26.000ns 0.9v 27.000ns 0.9v 27.000ns 0.9v 27.025ns 0.0v 28.000ns 0.0v 29.000ns 0.0v 30.000ns 0.0v 31.000ns 0.0v 31.000ns 0.0v 31.025ns 0.9v 32.000ns 0.9v 33.000ns 0.9v 33.000ns 0.9v 33.025ns 0.0v 34.000ns 0.0v 35.000ns 0.0v 36.000ns 0.0v 37.000ns 0.0v 37.000ns 0.0v 37.025ns 0.9v 38.000ns 0.9v 39.000ns 0.9v 39.000ns 0.9v 39.025ns 0.0v 40.000ns 0.0v 41.000ns 0.0v 42.000ns 0.0v 43.000ns 0.0v 43.000ns 0.0v 43.025ns 0.9v 44.000ns 0.9v 45.000ns 0.9v 45.000ns 0.9v 45.025ns 0.0v 46.000ns 0.0v 47.000ns 0.0v 48.000ns 0.0v 49.000ns 0.0v 49.000ns 0.0v 49.025ns 0.9v 50.000ns 0.9v 51.000ns 0.9v 51.000ns 0.9v 51.025ns 0.0v 52.000ns 0.0v 53.000ns 0.0v 54.000ns 0.0v 55.000ns 0.0v 55.000ns 0.0v 55.025ns 0.9v 56.000ns 0.9v 57.000ns 0.9v 57.000ns 0.9v 57.025ns 0.0v 58.000ns 0.0v 59.000ns 0.0v 60.000ns 0.0v 61.000ns 0.0v 61.000ns 0.0v 61.025ns 0.9v 62.000ns 0.9v 63.000ns 0.9v 63.000ns 0.9v 63.025ns 0.0v 64.000ns 0.0v 65.000ns 0.0v 66.000ns 0.0v 67.000ns 0.0v 67.000ns 0.0v 67.025ns 0.9v 68.000ns 0.9v 69.000ns 0.9v 69.000ns 0.9v 69.025ns 0.0v 70.000ns 0.0v 71.000ns 0.0v 72.000ns 0.0v 73.000ns 0.0v 73.000ns 0.0v 73.025ns 0.9v 74.000ns 0.9v 75.000ns 0.9v 75.000ns 0.9v 75.025ns 0.0v 76.000ns 0.0v 77.000ns 0.0v 78.000ns 0.0v 79.000ns 0.0v 79.000ns 0.0v 79.025ns 0.9v 80.000ns 0.9v 81.000ns 0.9v 81.000ns 0.9v 81.025ns 0.0v 82.000ns 0.0v 83.000ns 0.0v 84.000ns 0.0v 85.000ns 0.0v 85.000ns 0.0v 85.025ns 0.9v 86.000ns 0.9v 87.000ns 0.9v 87.000ns 0.9v 87.025ns 0.0v 88.000ns 0.0v 89.000ns 0.0v 90.000ns 0.0v 91.000ns 0.0v 91.000ns 0.0v 91.025ns 0.9v 92.000ns 0.9v 93.000ns 0.9v 93.000ns 0.9v 93.025ns 0.0v 94.000ns 0.0v 95.000ns 0.0v 96.000ns 0.0v 97.000ns 0.0v 97.000ns 0.0v 97.025ns 0.9v 98.000ns 0.9v 99.000ns 0.9v 99.000ns 0.9v 99.025ns 0.0v 100.000ns 0.0v 101.000ns 0.0v 102.000ns 0.0v 103.000ns 0.0v 103.000ns 0.0v 103.025ns 0.9v 104.000ns 0.9v 105.000ns 0.9v 105.000ns 0.9v 105.025ns 0.0v 106.000ns 0.0v 107.000ns 0.0v 108.000ns 0.0v 109.000ns 0.0v 109.000ns 0.0v 109.025ns 0.9v 110.000ns 0.9v 111.000ns 0.9v 111.000ns 0.9v 111.025ns 0.0v 112.000ns 0.0v 113.000ns 0.0v 114.000ns 0.0v 115.000ns 0.0v 115.000ns 0.0v 115.025ns 0.9v 116.000ns 0.9v 117.000ns 0.9v 117.000ns 0.9v 117.025ns 0.0v 118.000ns 0.0v 119.000ns 0.0v 120.000ns 0.0v 121.000ns 0.0v 121.000ns 0.0v 121.025ns 0.9v 122.000ns 0.9v 123.000ns 0.9v 123.000ns 0.9v 123.025ns 0.0v 124.000ns 0.0v 125.000ns 0.0v 126.000ns 0.0v 127.000ns 0.0v 127.000ns 0.0v 127.025ns 0.9v 128.000ns 0.9v 129.000ns 0.9v 129.000ns 0.9v 129.025ns 0.0v 130.000ns 0.0v 131.000ns 0.0v 132.000ns 0.0v 133.000ns 0.0v 133.000ns 0.0v 133.025ns 0.9v 134.000ns 0.9v 135.000ns 0.9v 135.000ns 0.9v 135.025ns 0.0v 136.000ns 0.0v 137.000ns 0.0v 138.000ns 0.0v 139.000ns 0.0v 139.000ns 0.0v 139.025ns 0.9v 140.000ns 0.9v 141.000ns 0.9v 141.000ns 0.9v 141.025ns 0.0v 142.000ns 0.0v 143.000ns 0.0v 144.000ns 0.0v 145.000ns 0.0v 145.000ns 0.0v 145.025ns 0.9v 146.000ns 0.9v 147.000ns 0.9v 147.000ns 0.9v 147.025ns 0.0v 148.000ns 0.0v 149.000ns 0.0v 150.000ns 0.0v 151.000ns 0.0v 151.000ns 0.0v 151.025ns 0.9v 152.000ns 0.9v 153.000ns 0.9v 153.000ns 0.9v 153.025ns 0.0v 154.000ns 0.0v 155.000ns 0.0v 156.000ns 0.0v 157.000ns 0.0v 157.000ns 0.0v 157.025ns 0.9v 158.000ns 0.9v 159.000ns 0.9v 159.000ns 0.9v 159.025ns 0.0v 160.000ns 0.0v 161.000ns 0.0v 162.000ns 0.0v 163.000ns 0.0v 163.000ns 0.0v 163.025ns 0.9v 164.000ns 0.9v 165.000ns 0.9v 165.000ns 0.9v 165.025ns 0.0v 166.000ns 0.0v 167.000ns 0.0v 168.000ns 0.0v 169.000ns 0.0v 169.000ns 0.0v 169.025ns 0.9v 170.000ns 0.9v 171.000ns 0.9v 171.000ns 0.9v 171.025ns 0.0v 172.000ns 0.0v 173.000ns 0.0v 174.000ns 0.0v 175.000ns 0.0v 175.000ns 0.0v 175.025ns 0.9v 176.000ns 0.9v 177.000ns 0.9v 177.000ns 0.9v 177.025ns 0.0v 178.000ns 0.0v 179.000ns 0.0v 180.000ns 0.0v 181.000ns 0.0v 181.000ns 0.0v 181.025ns 0.9v 182.000ns 0.9v 183.000ns 0.9v 183.000ns 0.9v 183.025ns 0.0v 184.000ns 0.0v 185.000ns 0.0v 186.000ns 0.0v 187.000ns 0.0v 187.000ns 0.0v 187.025ns 0.9v 188.000ns 0.9v 189.000ns 0.9v 189.000ns 0.9v 189.025ns 0.0v 190.000ns 0.0v 191.000ns 0.0v 192.000ns 0.0v 193.000ns 0.0v 193.000ns 0.0v 193.025ns 0.9v 194.000ns 0.9v 195.000ns 0.9v 195.000ns 0.9v 195.025ns 0.0v 196.000ns 0.0v 197.000ns 0.0v 198.000ns 0.0v 199.000ns 0.0v 199.000ns 0.0v 199.025ns 0.9v 200.000ns 0.9v 201.000ns 0.9v 201.000ns 0.9v 201.025ns 0.0v 202.000ns 0.0v 203.000ns 0.0v 204.000ns 0.0v 205.000ns 0.0v 205.000ns 0.0v 205.025ns 0.9v 206.000ns 0.9v 207.000ns 0.9v 207.000ns 0.9v 207.025ns 0.0v 208.000ns 0.0v 209.000ns 0.0v 210.000ns 0.0v 211.000ns 0.0v 211.000ns 0.0v 211.025ns 0.9v 212.000ns 0.9v 213.000ns 0.9v 213.000ns 0.9v 213.025ns 0.0v 214.000ns 0.0v 215.000ns 0.0v 216.000ns 0.0v 217.000ns 0.0v 217.000ns 0.0v 217.025ns 0.9v 218.000ns 0.9v 219.000ns 0.9v 219.000ns 0.9v 219.025ns 0.0v 220.000ns 0.0v 221.000ns 0.0v 222.000ns 0.0v 223.000ns 0.0v 223.000ns 0.0v 223.025ns 0.9v 224.000ns 0.9v 225.000ns 0.9v 225.000ns 0.9v 225.025ns 0.0v 226.000ns 0.0v 227.000ns 0.0v 228.000ns 0.0v 229.000ns 0.0v 229.000ns 0.0v 229.025ns 0.9v 230.000ns 0.9v 231.000ns 0.9v 231.000ns 0.9v 231.025ns 0.0v 232.000ns 0.0v 233.000ns 0.0v 234.000ns 0.0v 235.000ns 0.0v 235.000ns 0.0v 235.025ns 0.9v 236.000ns 0.9v 237.000ns 0.9v 237.000ns 0.9v 237.025ns 0.0v 238.000ns 0.0v 239.000ns 0.0v 240.000ns 0.0v 241.000ns 0.0v 241.000ns 0.0v 241.025ns 0.9v 242.000ns 0.9v

vW10_0 W10<0> 0 pwl 0ns 0.0v 0.000ns 0.0v 0.025ns 0.9v 1.000ns 0.9v 2.000ns 0.9v 3.000ns 0.9v 4.000ns 0.9v 4.000ns 0.9v 4.025ns 0.0v 5.000ns 0.0v 6.000ns 0.0v 6.000ns 0.0v 6.025ns 0.9v 7.000ns 0.9v 8.000ns 0.9v 9.000ns 0.9v 10.000ns 0.9v 10.000ns 0.9v 10.025ns 0.0v 11.000ns 0.0v 12.000ns 0.0v 12.000ns 0.0v 12.025ns 0.9v 13.000ns 0.9v 14.000ns 0.9v 15.000ns 0.9v 16.000ns 0.9v 16.000ns 0.9v 16.025ns 0.0v 17.000ns 0.0v 18.000ns 0.0v 18.000ns 0.0v 18.025ns 0.9v 19.000ns 0.9v 20.000ns 0.9v 21.000ns 0.9v 22.000ns 0.9v 22.000ns 0.9v 22.025ns 0.0v 23.000ns 0.0v 24.000ns 0.0v 24.000ns 0.0v 24.025ns 0.9v 25.000ns 0.9v 26.000ns 0.9v 27.000ns 0.9v 28.000ns 0.9v 28.000ns 0.9v 28.025ns 0.0v 29.000ns 0.0v 30.000ns 0.0v 30.000ns 0.0v 30.025ns 0.9v 31.000ns 0.9v 32.000ns 0.9v 33.000ns 0.9v 34.000ns 0.9v 34.000ns 0.9v 34.025ns 0.0v 35.000ns 0.0v 36.000ns 0.0v 36.000ns 0.0v 36.025ns 0.9v 37.000ns 0.9v 38.000ns 0.9v 39.000ns 0.9v 40.000ns 0.9v 40.000ns 0.9v 40.025ns 0.0v 41.000ns 0.0v 42.000ns 0.0v 42.000ns 0.0v 42.025ns 0.9v 43.000ns 0.9v 44.000ns 0.9v 45.000ns 0.9v 46.000ns 0.9v 46.000ns 0.9v 46.025ns 0.0v 47.000ns 0.0v 48.000ns 0.0v 48.000ns 0.0v 48.025ns 0.9v 49.000ns 0.9v 50.000ns 0.9v 51.000ns 0.9v 52.000ns 0.9v 52.000ns 0.9v 52.025ns 0.0v 53.000ns 0.0v 54.000ns 0.0v 54.000ns 0.0v 54.025ns 0.9v 55.000ns 0.9v 56.000ns 0.9v 57.000ns 0.9v 58.000ns 0.9v 58.000ns 0.9v 58.025ns 0.0v 59.000ns 0.0v 60.000ns 0.0v 60.000ns 0.0v 60.025ns 0.9v 61.000ns 0.9v 62.000ns 0.9v 63.000ns 0.9v 64.000ns 0.9v 64.000ns 0.9v 64.025ns 0.0v 65.000ns 0.0v 66.000ns 0.0v 66.000ns 0.0v 66.025ns 0.9v 67.000ns 0.9v 68.000ns 0.9v 69.000ns 0.9v 70.000ns 0.9v 70.000ns 0.9v 70.025ns 0.0v 71.000ns 0.0v 72.000ns 0.0v 72.000ns 0.0v 72.025ns 0.9v 73.000ns 0.9v 74.000ns 0.9v 75.000ns 0.9v 76.000ns 0.9v 76.000ns 0.9v 76.025ns 0.0v 77.000ns 0.0v 78.000ns 0.0v 78.000ns 0.0v 78.025ns 0.9v 79.000ns 0.9v 80.000ns 0.9v 81.000ns 0.9v 82.000ns 0.9v 82.000ns 0.9v 82.025ns 0.0v 83.000ns 0.0v 84.000ns 0.0v 84.000ns 0.0v 84.025ns 0.9v 85.000ns 0.9v 86.000ns 0.9v 87.000ns 0.9v 88.000ns 0.9v 88.000ns 0.9v 88.025ns 0.0v 89.000ns 0.0v 90.000ns 0.0v 90.000ns 0.0v 90.025ns 0.9v 91.000ns 0.9v 92.000ns 0.9v 93.000ns 0.9v 94.000ns 0.9v 94.000ns 0.9v 94.025ns 0.0v 95.000ns 0.0v 96.000ns 0.0v 96.000ns 0.0v 96.025ns 0.9v 97.000ns 0.9v 98.000ns 0.9v 99.000ns 0.9v 100.000ns 0.9v 100.000ns 0.9v 100.025ns 0.0v 101.000ns 0.0v 102.000ns 0.0v 102.000ns 0.0v 102.025ns 0.9v 103.000ns 0.9v 104.000ns 0.9v 105.000ns 0.9v 106.000ns 0.9v 106.000ns 0.9v 106.025ns 0.0v 107.000ns 0.0v 108.000ns 0.0v 108.000ns 0.0v 108.025ns 0.9v 109.000ns 0.9v 110.000ns 0.9v 111.000ns 0.9v 112.000ns 0.9v 112.000ns 0.9v 112.025ns 0.0v 113.000ns 0.0v 114.000ns 0.0v 114.000ns 0.0v 114.025ns 0.9v 115.000ns 0.9v 116.000ns 0.9v 117.000ns 0.9v 118.000ns 0.9v 118.000ns 0.9v 118.025ns 0.0v 119.000ns 0.0v 120.000ns 0.0v 120.000ns 0.0v 120.025ns 0.9v 121.000ns 0.9v 122.000ns 0.9v 123.000ns 0.9v 124.000ns 0.9v 124.000ns 0.9v 124.025ns 0.0v 125.000ns 0.0v 126.000ns 0.0v 126.000ns 0.0v 126.025ns 0.9v 127.000ns 0.9v 128.000ns 0.9v 129.000ns 0.9v 130.000ns 0.9v 130.000ns 0.9v 130.025ns 0.0v 131.000ns 0.0v 132.000ns 0.0v 132.000ns 0.0v 132.025ns 0.9v 133.000ns 0.9v 134.000ns 0.9v 135.000ns 0.9v 136.000ns 0.9v 136.000ns 0.9v 136.025ns 0.0v 137.000ns 0.0v 138.000ns 0.0v 138.000ns 0.0v 138.025ns 0.9v 139.000ns 0.9v 140.000ns 0.9v 141.000ns 0.9v 142.000ns 0.9v 142.000ns 0.9v 142.025ns 0.0v 143.000ns 0.0v 144.000ns 0.0v 144.000ns 0.0v 144.025ns 0.9v 145.000ns 0.9v 146.000ns 0.9v 147.000ns 0.9v 148.000ns 0.9v 148.000ns 0.9v 148.025ns 0.0v 149.000ns 0.0v 150.000ns 0.0v 150.000ns 0.0v 150.025ns 0.9v 151.000ns 0.9v 152.000ns 0.9v 153.000ns 0.9v 154.000ns 0.9v 154.000ns 0.9v 154.025ns 0.0v 155.000ns 0.0v 156.000ns 0.0v 156.000ns 0.0v 156.025ns 0.9v 157.000ns 0.9v 158.000ns 0.9v 159.000ns 0.9v 160.000ns 0.9v 160.000ns 0.9v 160.025ns 0.0v 161.000ns 0.0v 162.000ns 0.0v 162.000ns 0.0v 162.025ns 0.9v 163.000ns 0.9v 164.000ns 0.9v 165.000ns 0.9v 166.000ns 0.9v 166.000ns 0.9v 166.025ns 0.0v 167.000ns 0.0v 168.000ns 0.0v 168.000ns 0.0v 168.025ns 0.9v 169.000ns 0.9v 170.000ns 0.9v 171.000ns 0.9v 172.000ns 0.9v 172.000ns 0.9v 172.025ns 0.0v 173.000ns 0.0v 174.000ns 0.0v 174.000ns 0.0v 174.025ns 0.9v 175.000ns 0.9v 176.000ns 0.9v 177.000ns 0.9v 178.000ns 0.9v 178.000ns 0.9v 178.025ns 0.0v 179.000ns 0.0v 180.000ns 0.0v 180.000ns 0.0v 180.025ns 0.9v 181.000ns 0.9v 182.000ns 0.9v 183.000ns 0.9v 184.000ns 0.9v 184.000ns 0.9v 184.025ns 0.0v 185.000ns 0.0v 186.000ns 0.0v 186.000ns 0.0v 186.025ns 0.9v 187.000ns 0.9v 188.000ns 0.9v 189.000ns 0.9v 190.000ns 0.9v 190.000ns 0.9v 190.025ns 0.0v 191.000ns 0.0v 192.000ns 0.0v 192.000ns 0.0v 192.025ns 0.9v 193.000ns 0.9v 194.000ns 0.9v 195.000ns 0.9v 196.000ns 0.9v 196.000ns 0.9v 196.025ns 0.0v 197.000ns 0.0v 198.000ns 0.0v 198.000ns 0.0v 198.025ns 0.9v 199.000ns 0.9v 200.000ns 0.9v 201.000ns 0.9v 202.000ns 0.9v 202.000ns 0.9v 202.025ns 0.0v 203.000ns 0.0v 204.000ns 0.0v 204.000ns 0.0v 204.025ns 0.9v 205.000ns 0.9v 206.000ns 0.9v 207.000ns 0.9v 208.000ns 0.9v 208.000ns 0.9v 208.025ns 0.0v 209.000ns 0.0v 210.000ns 0.0v 210.000ns 0.0v 210.025ns 0.9v 211.000ns 0.9v 212.000ns 0.9v 213.000ns 0.9v 214.000ns 0.9v 214.000ns 0.9v 214.025ns 0.0v 215.000ns 0.0v 216.000ns 0.0v 216.000ns 0.0v 216.025ns 0.9v 217.000ns 0.9v 218.000ns 0.9v 219.000ns 0.9v 220.000ns 0.9v 220.000ns 0.9v 220.025ns 0.0v 221.000ns 0.0v 222.000ns 0.0v 222.000ns 0.0v 222.025ns 0.9v 223.000ns 0.9v 224.000ns 0.9v 225.000ns 0.9v 226.000ns 0.9v 226.000ns 0.9v 226.025ns 0.0v 227.000ns 0.0v 228.000ns 0.0v 228.000ns 0.0v 228.025ns 0.9v 229.000ns 0.9v 230.000ns 0.9v 231.000ns 0.9v 232.000ns 0.9v 232.000ns 0.9v 232.025ns 0.0v 233.000ns 0.0v 234.000ns 0.0v 234.000ns 0.0v 234.025ns 0.9v 235.000ns 0.9v 236.000ns 0.9v 237.000ns 0.9v 238.000ns 0.9v 238.000ns 0.9v 238.025ns 0.0v 239.000ns 0.0v 240.000ns 0.0v 240.000ns 0.0v 240.025ns 0.9v 241.000ns 0.9v 242.000ns 0.9v

vW20_2 W20<2> 0 pwl 0ns 0.0v 1.000ns 0.0v 2.000ns 0.0v 3.000ns 0.0v 4.000ns 0.0v 5.000ns 0.0v 5.000ns 0.0v 5.025ns 0.9v 6.000ns 0.9v 7.000ns 0.9v 8.000ns 0.9v 9.000ns 0.9v 10.000ns 0.9v 11.000ns 0.9v 11.000ns 0.9v 11.025ns 0.0v 12.000ns 0.0v 13.000ns 0.0v 14.000ns 0.0v 15.000ns 0.0v 16.000ns 0.0v 17.000ns 0.0v 18.000ns 0.0v 19.000ns 0.0v 20.000ns 0.0v 21.000ns 0.0v 22.000ns 0.0v 23.000ns 0.0v 23.000ns 0.0v 23.025ns 0.9v 24.000ns 0.9v 25.000ns 0.9v 26.000ns 0.9v 27.000ns 0.9v 28.000ns 0.9v 29.000ns 0.9v 29.000ns 0.9v 29.025ns 0.0v 30.000ns 0.0v 31.000ns 0.0v 32.000ns 0.0v 33.000ns 0.0v 34.000ns 0.0v 35.000ns 0.0v 36.000ns 0.0v 37.000ns 0.0v 38.000ns 0.0v 39.000ns 0.0v 40.000ns 0.0v 41.000ns 0.0v 41.000ns 0.0v 41.025ns 0.9v 42.000ns 0.9v 43.000ns 0.9v 44.000ns 0.9v 45.000ns 0.9v 46.000ns 0.9v 47.000ns 0.9v 47.000ns 0.9v 47.025ns 0.0v 48.000ns 0.0v 49.000ns 0.0v 50.000ns 0.0v 51.000ns 0.0v 52.000ns 0.0v 53.000ns 0.0v 54.000ns 0.0v 55.000ns 0.0v 56.000ns 0.0v 57.000ns 0.0v 58.000ns 0.0v 59.000ns 0.0v 59.000ns 0.0v 59.025ns 0.9v 60.000ns 0.9v 61.000ns 0.9v 62.000ns 0.9v 63.000ns 0.9v 64.000ns 0.9v 65.000ns 0.9v 65.000ns 0.9v 65.025ns 0.0v 66.000ns 0.0v 67.000ns 0.0v 68.000ns 0.0v 69.000ns 0.0v 70.000ns 0.0v 71.000ns 0.0v 72.000ns 0.0v 73.000ns 0.0v 74.000ns 0.0v 75.000ns 0.0v 76.000ns 0.0v 77.000ns 0.0v 77.000ns 0.0v 77.025ns 0.9v 78.000ns 0.9v 79.000ns 0.9v 80.000ns 0.9v 81.000ns 0.9v 82.000ns 0.9v 83.000ns 0.9v 83.000ns 0.9v 83.025ns 0.0v 84.000ns 0.0v 85.000ns 0.0v 86.000ns 0.0v 87.000ns 0.0v 88.000ns 0.0v 89.000ns 0.0v 90.000ns 0.0v 91.000ns 0.0v 92.000ns 0.0v 93.000ns 0.0v 94.000ns 0.0v 95.000ns 0.0v 95.000ns 0.0v 95.025ns 0.9v 96.000ns 0.9v 97.000ns 0.9v 98.000ns 0.9v 99.000ns 0.9v 100.000ns 0.9v 101.000ns 0.9v 101.000ns 0.9v 101.025ns 0.0v 102.000ns 0.0v 103.000ns 0.0v 104.000ns 0.0v 105.000ns 0.0v 106.000ns 0.0v 107.000ns 0.0v 108.000ns 0.0v 109.000ns 0.0v 110.000ns 0.0v 111.000ns 0.0v 112.000ns 0.0v 113.000ns 0.0v 113.000ns 0.0v 113.025ns 0.9v 114.000ns 0.9v 115.000ns 0.9v 116.000ns 0.9v 117.000ns 0.9v 118.000ns 0.9v 119.000ns 0.9v 119.000ns 0.9v 119.025ns 0.0v 120.000ns 0.0v 121.000ns 0.0v 122.000ns 0.0v 123.000ns 0.0v 124.000ns 0.0v 125.000ns 0.0v 126.000ns 0.0v 127.000ns 0.0v 128.000ns 0.0v 129.000ns 0.0v 130.000ns 0.0v 131.000ns 0.0v 131.000ns 0.0v 131.025ns 0.9v 132.000ns 0.9v 133.000ns 0.9v 134.000ns 0.9v 135.000ns 0.9v 136.000ns 0.9v 137.000ns 0.9v 137.000ns 0.9v 137.025ns 0.0v 138.000ns 0.0v 139.000ns 0.0v 140.000ns 0.0v 141.000ns 0.0v 142.000ns 0.0v 143.000ns 0.0v 144.000ns 0.0v 145.000ns 0.0v 146.000ns 0.0v 147.000ns 0.0v 148.000ns 0.0v 149.000ns 0.0v 149.000ns 0.0v 149.025ns 0.9v 150.000ns 0.9v 151.000ns 0.9v 152.000ns 0.9v 153.000ns 0.9v 154.000ns 0.9v 155.000ns 0.9v 155.000ns 0.9v 155.025ns 0.0v 156.000ns 0.0v 157.000ns 0.0v 158.000ns 0.0v 159.000ns 0.0v 160.000ns 0.0v 161.000ns 0.0v 162.000ns 0.0v 163.000ns 0.0v 164.000ns 0.0v 165.000ns 0.0v 166.000ns 0.0v 167.000ns 0.0v 167.000ns 0.0v 167.025ns 0.9v 168.000ns 0.9v 169.000ns 0.9v 170.000ns 0.9v 171.000ns 0.9v 172.000ns 0.9v 173.000ns 0.9v 173.000ns 0.9v 173.025ns 0.0v 174.000ns 0.0v 175.000ns 0.0v 176.000ns 0.0v 177.000ns 0.0v 178.000ns 0.0v 179.000ns 0.0v 180.000ns 0.0v 181.000ns 0.0v 182.000ns 0.0v 183.000ns 0.0v 184.000ns 0.0v 185.000ns 0.0v 185.000ns 0.0v 185.025ns 0.9v 186.000ns 0.9v 187.000ns 0.9v 188.000ns 0.9v 189.000ns 0.9v 190.000ns 0.9v 191.000ns 0.9v 191.000ns 0.9v 191.025ns 0.0v 192.000ns 0.0v 193.000ns 0.0v 194.000ns 0.0v 195.000ns 0.0v 196.000ns 0.0v 197.000ns 0.0v 198.000ns 0.0v 199.000ns 0.0v 200.000ns 0.0v 201.000ns 0.0v 202.000ns 0.0v 203.000ns 0.0v 203.000ns 0.0v 203.025ns 0.9v 204.000ns 0.9v 205.000ns 0.9v 206.000ns 0.9v 207.000ns 0.9v 208.000ns 0.9v 209.000ns 0.9v 209.000ns 0.9v 209.025ns 0.0v 210.000ns 0.0v 211.000ns 0.0v 212.000ns 0.0v 213.000ns 0.0v 214.000ns 0.0v 215.000ns 0.0v 216.000ns 0.0v 217.000ns 0.0v 218.000ns 0.0v 219.000ns 0.0v 220.000ns 0.0v 221.000ns 0.0v 221.000ns 0.0v 221.025ns 0.9v 222.000ns 0.9v 223.000ns 0.9v 224.000ns 0.9v 225.000ns 0.9v 226.000ns 0.9v 227.000ns 0.9v 227.000ns 0.9v 227.025ns 0.0v 228.000ns 0.0v 229.000ns 0.0v 230.000ns 0.0v 231.000ns 0.0v 232.000ns 0.0v 233.000ns 0.0v 234.000ns 0.0v 235.000ns 0.0v 236.000ns 0.0v 237.000ns 0.0v 238.000ns 0.0v 239.000ns 0.0v 239.000ns 0.0v 239.025ns 0.9v 240.000ns 0.9v 241.000ns 0.9v 242.000ns 0.9v

vW20_1 W20<1> 0 pwl 0ns 0.0v 1.000ns 0.0v 2.000ns 0.0v 3.000ns 0.0v 4.000ns 0.0v 5.000ns 0.0v 5.000ns 0.0v 5.025ns 0.9v 6.000ns 0.9v 7.000ns 0.9v 8.000ns 0.9v 9.000ns 0.9v 10.000ns 0.9v 11.000ns 0.9v 11.000ns 0.9v 11.025ns 0.0v 12.000ns 0.0v 13.000ns 0.0v 14.000ns 0.0v 15.000ns 0.0v 16.000ns 0.0v 17.000ns 0.0v 18.000ns 0.0v 19.000ns 0.0v 20.000ns 0.0v 21.000ns 0.0v 22.000ns 0.0v 23.000ns 0.0v 23.000ns 0.0v 23.025ns 0.9v 24.000ns 0.9v 25.000ns 0.9v 26.000ns 0.9v 27.000ns 0.9v 28.000ns 0.9v 29.000ns 0.9v 29.000ns 0.9v 29.025ns 0.0v 30.000ns 0.0v 31.000ns 0.0v 32.000ns 0.0v 33.000ns 0.0v 34.000ns 0.0v 35.000ns 0.0v 36.000ns 0.0v 37.000ns 0.0v 38.000ns 0.0v 39.000ns 0.0v 40.000ns 0.0v 41.000ns 0.0v 41.000ns 0.0v 41.025ns 0.9v 42.000ns 0.9v 43.000ns 0.9v 44.000ns 0.9v 45.000ns 0.9v 46.000ns 0.9v 47.000ns 0.9v 47.000ns 0.9v 47.025ns 0.0v 48.000ns 0.0v 49.000ns 0.0v 50.000ns 0.0v 51.000ns 0.0v 52.000ns 0.0v 53.000ns 0.0v 54.000ns 0.0v 55.000ns 0.0v 56.000ns 0.0v 57.000ns 0.0v 58.000ns 0.0v 59.000ns 0.0v 59.000ns 0.0v 59.025ns 0.9v 60.000ns 0.9v 61.000ns 0.9v 62.000ns 0.9v 63.000ns 0.9v 64.000ns 0.9v 65.000ns 0.9v 65.000ns 0.9v 65.025ns 0.0v 66.000ns 0.0v 67.000ns 0.0v 68.000ns 0.0v 69.000ns 0.0v 70.000ns 0.0v 71.000ns 0.0v 72.000ns 0.0v 73.000ns 0.0v 74.000ns 0.0v 75.000ns 0.0v 76.000ns 0.0v 77.000ns 0.0v 77.000ns 0.0v 77.025ns 0.9v 78.000ns 0.9v 79.000ns 0.9v 80.000ns 0.9v 81.000ns 0.9v 82.000ns 0.9v 83.000ns 0.9v 83.000ns 0.9v 83.025ns 0.0v 84.000ns 0.0v 85.000ns 0.0v 86.000ns 0.0v 87.000ns 0.0v 88.000ns 0.0v 89.000ns 0.0v 90.000ns 0.0v 91.000ns 0.0v 92.000ns 0.0v 93.000ns 0.0v 94.000ns 0.0v 95.000ns 0.0v 95.000ns 0.0v 95.025ns 0.9v 96.000ns 0.9v 97.000ns 0.9v 98.000ns 0.9v 99.000ns 0.9v 100.000ns 0.9v 101.000ns 0.9v 101.000ns 0.9v 101.025ns 0.0v 102.000ns 0.0v 103.000ns 0.0v 104.000ns 0.0v 105.000ns 0.0v 106.000ns 0.0v 107.000ns 0.0v 108.000ns 0.0v 109.000ns 0.0v 110.000ns 0.0v 111.000ns 0.0v 112.000ns 0.0v 113.000ns 0.0v 113.000ns 0.0v 113.025ns 0.9v 114.000ns 0.9v 115.000ns 0.9v 116.000ns 0.9v 117.000ns 0.9v 118.000ns 0.9v 119.000ns 0.9v 119.000ns 0.9v 119.025ns 0.0v 120.000ns 0.0v 121.000ns 0.0v 122.000ns 0.0v 123.000ns 0.0v 124.000ns 0.0v 125.000ns 0.0v 126.000ns 0.0v 127.000ns 0.0v 128.000ns 0.0v 129.000ns 0.0v 130.000ns 0.0v 131.000ns 0.0v 131.000ns 0.0v 131.025ns 0.9v 132.000ns 0.9v 133.000ns 0.9v 134.000ns 0.9v 135.000ns 0.9v 136.000ns 0.9v 137.000ns 0.9v 137.000ns 0.9v 137.025ns 0.0v 138.000ns 0.0v 139.000ns 0.0v 140.000ns 0.0v 141.000ns 0.0v 142.000ns 0.0v 143.000ns 0.0v 144.000ns 0.0v 145.000ns 0.0v 146.000ns 0.0v 147.000ns 0.0v 148.000ns 0.0v 149.000ns 0.0v 149.000ns 0.0v 149.025ns 0.9v 150.000ns 0.9v 151.000ns 0.9v 152.000ns 0.9v 153.000ns 0.9v 154.000ns 0.9v 155.000ns 0.9v 155.000ns 0.9v 155.025ns 0.0v 156.000ns 0.0v 157.000ns 0.0v 158.000ns 0.0v 159.000ns 0.0v 160.000ns 0.0v 161.000ns 0.0v 162.000ns 0.0v 163.000ns 0.0v 164.000ns 0.0v 165.000ns 0.0v 166.000ns 0.0v 167.000ns 0.0v 167.000ns 0.0v 167.025ns 0.9v 168.000ns 0.9v 169.000ns 0.9v 170.000ns 0.9v 171.000ns 0.9v 172.000ns 0.9v 173.000ns 0.9v 173.000ns 0.9v 173.025ns 0.0v 174.000ns 0.0v 175.000ns 0.0v 176.000ns 0.0v 177.000ns 0.0v 178.000ns 0.0v 179.000ns 0.0v 180.000ns 0.0v 181.000ns 0.0v 182.000ns 0.0v 183.000ns 0.0v 184.000ns 0.0v 185.000ns 0.0v 185.000ns 0.0v 185.025ns 0.9v 186.000ns 0.9v 187.000ns 0.9v 188.000ns 0.9v 189.000ns 0.9v 190.000ns 0.9v 191.000ns 0.9v 191.000ns 0.9v 191.025ns 0.0v 192.000ns 0.0v 193.000ns 0.0v 194.000ns 0.0v 195.000ns 0.0v 196.000ns 0.0v 197.000ns 0.0v 198.000ns 0.0v 199.000ns 0.0v 200.000ns 0.0v 201.000ns 0.0v 202.000ns 0.0v 203.000ns 0.0v 203.000ns 0.0v 203.025ns 0.9v 204.000ns 0.9v 205.000ns 0.9v 206.000ns 0.9v 207.000ns 0.9v 208.000ns 0.9v 209.000ns 0.9v 209.000ns 0.9v 209.025ns 0.0v 210.000ns 0.0v 211.000ns 0.0v 212.000ns 0.0v 213.000ns 0.0v 214.000ns 0.0v 215.000ns 0.0v 216.000ns 0.0v 217.000ns 0.0v 218.000ns 0.0v 219.000ns 0.0v 220.000ns 0.0v 221.000ns 0.0v 221.000ns 0.0v 221.025ns 0.9v 222.000ns 0.9v 223.000ns 0.9v 224.000ns 0.9v 225.000ns 0.9v 226.000ns 0.9v 227.000ns 0.9v 227.000ns 0.9v 227.025ns 0.0v 228.000ns 0.0v 229.000ns 0.0v 230.000ns 0.0v 231.000ns 0.0v 232.000ns 0.0v 233.000ns 0.0v 234.000ns 0.0v 235.000ns 0.0v 236.000ns 0.0v 237.000ns 0.0v 238.000ns 0.0v 239.000ns 0.0v 239.000ns 0.0v 239.025ns 0.9v 240.000ns 0.9v 241.000ns 0.9v 242.000ns 0.9v

vW20_0 W20<0> 0 pwl 0ns 0.0v 1.000ns 0.0v 2.000ns 0.0v 2.000ns 0.0v 2.025ns 0.9v 3.000ns 0.9v 4.000ns 0.9v 5.000ns 0.9v 6.000ns 0.9v 7.000ns 0.9v 8.000ns 0.9v 9.000ns 0.9v 10.000ns 0.9v 11.000ns 0.9v 12.000ns 0.9v 13.000ns 0.9v 14.000ns 0.9v 14.000ns 0.9v 14.025ns 0.0v 15.000ns 0.0v 16.000ns 0.0v 17.000ns 0.0v 18.000ns 0.0v 19.000ns 0.0v 20.000ns 0.0v 20.000ns 0.0v 20.025ns 0.9v 21.000ns 0.9v 22.000ns 0.9v 23.000ns 0.9v 24.000ns 0.9v 25.000ns 0.9v 26.000ns 0.9v 27.000ns 0.9v 28.000ns 0.9v 29.000ns 0.9v 30.000ns 0.9v 31.000ns 0.9v 32.000ns 0.9v 32.000ns 0.9v 32.025ns 0.0v 33.000ns 0.0v 34.000ns 0.0v 35.000ns 0.0v 36.000ns 0.0v 37.000ns 0.0v 38.000ns 0.0v 38.000ns 0.0v 38.025ns 0.9v 39.000ns 0.9v 40.000ns 0.9v 41.000ns 0.9v 42.000ns 0.9v 43.000ns 0.9v 44.000ns 0.9v 45.000ns 0.9v 46.000ns 0.9v 47.000ns 0.9v 48.000ns 0.9v 49.000ns 0.9v 50.000ns 0.9v 50.000ns 0.9v 50.025ns 0.0v 51.000ns 0.0v 52.000ns 0.0v 53.000ns 0.0v 54.000ns 0.0v 55.000ns 0.0v 56.000ns 0.0v 56.000ns 0.0v 56.025ns 0.9v 57.000ns 0.9v 58.000ns 0.9v 59.000ns 0.9v 60.000ns 0.9v 61.000ns 0.9v 62.000ns 0.9v 63.000ns 0.9v 64.000ns 0.9v 65.000ns 0.9v 66.000ns 0.9v 67.000ns 0.9v 68.000ns 0.9v 68.000ns 0.9v 68.025ns 0.0v 69.000ns 0.0v 70.000ns 0.0v 71.000ns 0.0v 72.000ns 0.0v 73.000ns 0.0v 74.000ns 0.0v 74.000ns 0.0v 74.025ns 0.9v 75.000ns 0.9v 76.000ns 0.9v 77.000ns 0.9v 78.000ns 0.9v 79.000ns 0.9v 80.000ns 0.9v 81.000ns 0.9v 82.000ns 0.9v 83.000ns 0.9v 84.000ns 0.9v 85.000ns 0.9v 86.000ns 0.9v 86.000ns 0.9v 86.025ns 0.0v 87.000ns 0.0v 88.000ns 0.0v 89.000ns 0.0v 90.000ns 0.0v 91.000ns 0.0v 92.000ns 0.0v 92.000ns 0.0v 92.025ns 0.9v 93.000ns 0.9v 94.000ns 0.9v 95.000ns 0.9v 96.000ns 0.9v 97.000ns 0.9v 98.000ns 0.9v 99.000ns 0.9v 100.000ns 0.9v 101.000ns 0.9v 102.000ns 0.9v 103.000ns 0.9v 104.000ns 0.9v 104.000ns 0.9v 104.025ns 0.0v 105.000ns 0.0v 106.000ns 0.0v 107.000ns 0.0v 108.000ns 0.0v 109.000ns 0.0v 110.000ns 0.0v 110.000ns 0.0v 110.025ns 0.9v 111.000ns 0.9v 112.000ns 0.9v 113.000ns 0.9v 114.000ns 0.9v 115.000ns 0.9v 116.000ns 0.9v 117.000ns 0.9v 118.000ns 0.9v 119.000ns 0.9v 120.000ns 0.9v 121.000ns 0.9v 122.000ns 0.9v 122.000ns 0.9v 122.025ns 0.0v 123.000ns 0.0v 124.000ns 0.0v 125.000ns 0.0v 126.000ns 0.0v 127.000ns 0.0v 128.000ns 0.0v 128.000ns 0.0v 128.025ns 0.9v 129.000ns 0.9v 130.000ns 0.9v 131.000ns 0.9v 132.000ns 0.9v 133.000ns 0.9v 134.000ns 0.9v 135.000ns 0.9v 136.000ns 0.9v 137.000ns 0.9v 138.000ns 0.9v 139.000ns 0.9v 140.000ns 0.9v 140.000ns 0.9v 140.025ns 0.0v 141.000ns 0.0v 142.000ns 0.0v 143.000ns 0.0v 144.000ns 0.0v 145.000ns 0.0v 146.000ns 0.0v 146.000ns 0.0v 146.025ns 0.9v 147.000ns 0.9v 148.000ns 0.9v 149.000ns 0.9v 150.000ns 0.9v 151.000ns 0.9v 152.000ns 0.9v 153.000ns 0.9v 154.000ns 0.9v 155.000ns 0.9v 156.000ns 0.9v 157.000ns 0.9v 158.000ns 0.9v 158.000ns 0.9v 158.025ns 0.0v 159.000ns 0.0v 160.000ns 0.0v 161.000ns 0.0v 162.000ns 0.0v 163.000ns 0.0v 164.000ns 0.0v 164.000ns 0.0v 164.025ns 0.9v 165.000ns 0.9v 166.000ns 0.9v 167.000ns 0.9v 168.000ns 0.9v 169.000ns 0.9v 170.000ns 0.9v 171.000ns 0.9v 172.000ns 0.9v 173.000ns 0.9v 174.000ns 0.9v 175.000ns 0.9v 176.000ns 0.9v 176.000ns 0.9v 176.025ns 0.0v 177.000ns 0.0v 178.000ns 0.0v 179.000ns 0.0v 180.000ns 0.0v 181.000ns 0.0v 182.000ns 0.0v 182.000ns 0.0v 182.025ns 0.9v 183.000ns 0.9v 184.000ns 0.9v 185.000ns 0.9v 186.000ns 0.9v 187.000ns 0.9v 188.000ns 0.9v 189.000ns 0.9v 190.000ns 0.9v 191.000ns 0.9v 192.000ns 0.9v 193.000ns 0.9v 194.000ns 0.9v 194.000ns 0.9v 194.025ns 0.0v 195.000ns 0.0v 196.000ns 0.0v 197.000ns 0.0v 198.000ns 0.0v 199.000ns 0.0v 200.000ns 0.0v 200.000ns 0.0v 200.025ns 0.9v 201.000ns 0.9v 202.000ns 0.9v 203.000ns 0.9v 204.000ns 0.9v 205.000ns 0.9v 206.000ns 0.9v 207.000ns 0.9v 208.000ns 0.9v 209.000ns 0.9v 210.000ns 0.9v 211.000ns 0.9v 212.000ns 0.9v 212.000ns 0.9v 212.025ns 0.0v 213.000ns 0.0v 214.000ns 0.0v 215.000ns 0.0v 216.000ns 0.0v 217.000ns 0.0v 218.000ns 0.0v 218.000ns 0.0v 218.025ns 0.9v 219.000ns 0.9v 220.000ns 0.9v 221.000ns 0.9v 222.000ns 0.9v 223.000ns 0.9v 224.000ns 0.9v 225.000ns 0.9v 226.000ns 0.9v 227.000ns 0.9v 228.000ns 0.9v 229.000ns 0.9v 230.000ns 0.9v 230.000ns 0.9v 230.025ns 0.0v 231.000ns 0.0v 232.000ns 0.0v 233.000ns 0.0v 234.000ns 0.0v 235.000ns 0.0v 236.000ns 0.0v 236.000ns 0.0v 236.025ns 0.9v 237.000ns 0.9v 238.000ns 0.9v 239.000ns 0.9v 240.000ns 0.9v 241.000ns 0.9v 242.000ns 0.9v

XDUT VSS VDD B<1> B<0> A<1> A<0> W10<0> W00<0> W10<1> W00<1> W20<0> W20<1> W20<2> Y<0> Y<1> Y<2> Neuron_OPT

.PROBE TRAN v(VDD) v(VSS) v(B<1>) v(B<0>) v(A<1>) v(A<0>) v(W10<0>) v(W00<0>) v(W10<1>) v(W00<1>) v(W20<0>) v(W20<1>) v(W20<2>) v(Y<0>) v(Y<1>) v(Y<2>)

.OP
.TRAN STEP=25p STOP=245n
.end
