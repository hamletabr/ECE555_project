ADE simulation setup
Run mode: Single Run, Sweeps and Corners
Tests:
  ECE555_XOR2_1: ECE555/XOR2/schematic, simulator hspiceD
