** Generated for: hspiceD
** Generated on: Nov  2 15:26:14 2025
** Design library name: ECE555
** Design cell name: OR2
** Design view name: schematic
** Library name: ECE555
** Cell name: OR2
** View name: schematic
mp5 y net5 vdd vdd pmos_rvt w=81e-9 l=20e-9 nfin=3
mp0 net7 a vdd vdd pmos_rvt w=162e-9 l=20e-9 nfin=6
mp1 net5 b net7 vdd pmos_rvt w=162e-9 l=20e-9 nfin=6
mn4 y net5 vss vss nmos_rvt w=54e-9 l=20e-9 nfin=2
mn3 net5 b vss vss nmos_rvt w=54e-9 l=20e-9 nfin=2
mn2 net5 a vss vss nmos_rvt w=54e-9 l=20e-9 nfin=2
.END
