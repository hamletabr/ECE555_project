ADE simulation setup
Test ECE555_OR2_1: ECE555/OR2/schematic, simulator hspiceD
Run mode: Single Run, Sweeps and Corners
