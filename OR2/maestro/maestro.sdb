ADE simulation setup
Run mode: Single Run, Sweeps and Corners
Tests:
  ECE555_OR2_1: ECE555/OR2/schematic, simulator hspiceD
