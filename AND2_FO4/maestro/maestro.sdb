ADE simulation setup
Run mode: Single Run, Sweeps and Corners
Tests:
  ECE555_AND2_FO4_1: ECE555/AND2_FO4/schematic, simulator hspiceD
