ADE simulation setup
Run mode: Single Run, Sweeps and Corners
Tests:
  ECE555_NOR2_1: ECE555/NOR2/schematic, simulator hspiceD
