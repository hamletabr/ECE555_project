ADE simulation setup
Test ECE555_NOR2_1: ECE555/NOR2/schematic, simulator hspiceD
Run mode: Single Run, Sweeps and Corners
