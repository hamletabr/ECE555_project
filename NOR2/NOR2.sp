** Generated for: hspiceD
** Generated on: Nov  2 15:36:34 2025
** Design library name: ECE555
** Design cell name: NOR2
** Design view name: schematic
** Library name: ECE555
** Cell name: NOR2
** View name: schematic
mp1 y b net1 vdd pmos_rvt w=162e-9 l=20e-9 nfin=6
mp0 net1 a vdd vdd pmos_rvt w=162e-9 l=20e-9 nfin=6
mn2 y a vss vss nmos_rvt w=54e-9 l=20e-9 nfin=2
mn3 y b vss vss nmos_rvt w=54e-9 l=20e-9 nfin=2
.END
