ADE simulation setup
Run mode: Single Run, Sweeps and Corners
Tests:
  ECE555_ADD3x3_1: ECE555/ADD3x3/schematic, simulator hspiceD
