ADE simulation setup
Run mode: Single Run, Sweeps and Corners
Tests:
  ECE555_INV_1: ECE555/INV/schematic, simulator spectre
