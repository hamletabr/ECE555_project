ADE simulation setup
Test ECE555_INV_1: ECE555/INV/schematic, simulator spectre
  Temperature: 27
Run mode: Single Run, Sweeps and Corners
