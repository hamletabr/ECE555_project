ADE simulation setup
Test ECE555_OR2_FO4_1: ECE555/OR2_FO4/schematic, simulator hspiceD
Run mode: Single Run, Sweeps and Corners
