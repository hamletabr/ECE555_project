** Generated for: hspiceD
** Generated on: Dec  5 07:42:14 2025
** Design library name: ECE555
** Design cell name: XOR2_OPT
** Design view name: schematic

** Library name: ECE555
** Cell name: XOR2_OPT
** View name: schematic
mn1 y b net1 net1 nmos_lvt w=27e-9 l=20e-9 nfin=1
mn0 net1 a vss vss nmos_lvt w=27e-9 l=20e-9 nfin=1
mp3 y b a a pmos_lvt w=27e-9 l=20e-9 nfin=1
mp2 net1 a vdd vdd pmos_lvt w=27e-9 l=20e-9 nfin=1
.END
