ADE simulation setup
Test ECE555_XOR2_OPT_1: ECE555/XOR2_OPT/schematic, simulator hspiceD
Run mode: Single Run, Sweeps and Corners
