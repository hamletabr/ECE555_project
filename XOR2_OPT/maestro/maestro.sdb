ADE simulation setup
Run mode: Single Run, Sweeps and Corners
Tests:
  ECE555_XOR2_OPT_1: ECE555/XOR2_OPT/schematic, simulator hspiceD
