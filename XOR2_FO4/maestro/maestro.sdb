ADE simulation setup
Run mode: Single Run, Sweeps and Corners
Tests:
  ECE555_XOR2_FO4_1: ECE555/XOR2_FO4/schematic, simulator hspiceD
