ADE simulation setup
Test ECE555_XOR2_FO4_1: ECE555/XOR2_FO4/schematic, simulator hspiceD
Run mode: Single Run, Sweeps and Corners
