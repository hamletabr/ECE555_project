ADE simulation setup
Test ECE555_MULT2x2_1: ECE555/MULT2x2/schematic, simulator hspiceD
Run mode: Single Run, Sweeps and Corners
